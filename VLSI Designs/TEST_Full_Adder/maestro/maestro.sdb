ADE simulation setup
Run mode: Single Run, Sweeps and Corners
Tests:
  ECE3421_TEST_Full_Adder_1: ECE3421/TEST_Full_Adder/schematic, simulator spectre
