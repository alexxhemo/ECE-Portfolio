ADE simulation setup
Test ECE3421_TEST_Full_Adder_1: ECE3421/TEST_Full_Adder/schematic, simulator spectre
  Models: /opt/cadence/installs/gpdk045_v_6_0/gpdk045/../models/spectre/gpdk045.scs[mc]
  Temperature: 27
  Analysis tran: stop=180n
  Signals: /clk, /A, /B, /C, /Full_Add_cout, /carry_out, /Full_Add_sum, /sum
Run mode: Single Run, Sweeps and Corners
