ADE simulation setup
Run mode: Single Run, Sweeps and Corners
Tests:
  ECE3421_Test_ms_reg_1: ECE3421/Test_ms_reg/schematic, simulator spectre
