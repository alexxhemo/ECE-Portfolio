ADE simulation setup
Test ECE3421_Test_ms_reg_1: ECE3421/Test_ms_reg/schematic, simulator spectre
  Models: /opt/cadence/installs/gpdk045_v_6_0/gpdk045/../models/spectre/gpdk045.scs[mc]
  Temperature: 27
  Analysis tran: stop=160n
  Signals: /Clk, /I0/Clk_not, /Q, /I0/Qm, /D
Run mode: Single Run, Sweeps and Corners
