ADE simulation setup
Run mode: Single Run, Sweeps and Corners
Tests:
  ECE3421_TEST_Static_MS_Reg_1: ECE3421/TEST_Static_MS_Reg/schematic, simulator spectre
    Variables: tdD = 11.05n:2p:11.07n
