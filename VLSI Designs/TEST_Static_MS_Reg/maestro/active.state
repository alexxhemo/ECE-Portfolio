ADE simulation setup
Test ECE3421_TEST_Static_MS_Reg_1: ECE3421/TEST_Static_MS_Reg/schematic, simulator spectre
  Models: /opt/cadence/installs/gpdk045_v_6_0/gpdk045/../models/spectre/gpdk045.scs[mc]
  Variables: tdD = 11.05n:2p:11.07n
  Temperature: 27
  Analysis tran: stop=80n
  Signals: /Clk, /D, /Q
Run mode: Single Run, Sweeps and Corners
